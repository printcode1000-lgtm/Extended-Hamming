* EH127 encoder benchmark: HYBRID_A
.include ../../models/65nm_bulk.pm
.include ../circuits.lib
.param VDD=1.2
.temp 27.0
VSUP VDD 0 {VDD}
VD1 D1 0 PULSE(0 1.2 1e-08 20p 20p 2e-08 4e-08)
VD2 D2 0 PULSE(0 1.2 8e-08 20p 20p 4e-08 8e-08)
VD3 D3 0 PULSE(0 1.2 8e-08 20p 20p 8e-08 1.6e-07)
VD4 D4 0 PULSE(0 1.2 8e-08 20p 20p 1.6e-07 3.2e-07)
VD5 D5 0 PULSE(0 1.2 8e-08 20p 20p 3.2e-07 6.4e-07)
VD6 D6 0 PULSE(0 1.2 8e-08 20p 20p 6.4e-07 1.28e-06)
VD7 D7 0 PULSE(0 1.2 8e-08 20p 20p 1.28e-06 2.56e-06)
XP1N1 D1 D2 P1N_1 VDD 0 XOR_HYBRID_A
XP1N2 P1N_1 D4 P1N_2 VDD 0 XOR_HYBRID_A
XP1N3 P1N_2 D5 P1N_3 VDD 0 XOR_HYBRID_A
XP1N4 P1N_3 D7 P1N_4 VDD 0 XOR_HYBRID_A
XP2N1 D1 D3 P2N_1 VDD 0 XOR_HYBRID_A
XP2N2 P2N_1 D4 P2N_2 VDD 0 XOR_HYBRID_A
XP2N3 P2N_2 D6 P2N_3 VDD 0 XOR_HYBRID_A
XP2N4 P2N_3 D7 P2N_4 VDD 0 XOR_HYBRID_A
XP4N1 D2 D3 P4N_1 VDD 0 XOR_HYBRID_A
XP4N2 P4N_1 D4 P4N_2 VDD 0 XOR_HYBRID_A
XP8N1 D5 D6 P8N_1 VDD 0 XOR_HYBRID_A
XP8N2 P8N_1 D7 P8N_2 VDD 0 XOR_HYBRID_A
XP0N1 D1 D2 P0N_1 VDD 0 XOR_HYBRID_A
XP0N2 P0N_1 D3 P0N_2 VDD 0 XOR_HYBRID_A
XP0N3 P0N_2 D4 P0N_3 VDD 0 XOR_HYBRID_A
XP0N4 P0N_3 D5 P0N_4 VDD 0 XOR_HYBRID_A
XP0N5 P0N_4 D6 P0N_5 VDD 0 XOR_HYBRID_A
XP0N6 P0N_5 D7 P0N_6 VDD 0 XOR_HYBRID_A
XP0N7 P0N_6 P1N_4 P0N_7 VDD 0 XOR_HYBRID_A
XP0N8 P0N_7 P2N_4 P0N_8 VDD 0 XOR_HYBRID_A
XP0N9 P0N_8 P4N_2 P0N_9 VDD 0 XOR_HYBRID_A
XP0N10 P0N_9 P8N_2 P0N_10 VDD 0 XOR_HYBRID_A
CLOAD_P1 P1N_4 0 10.0f
CLOAD_P2 P2N_4 0 10.0f
CLOAD_P4 P4N_2 0 10.0f
CLOAD_P8 P8N_2 0 10.0f
CLOAD_P0 P0N_10 0 10.0f
.tran 20p 6.4e-07 0 20p
.meas tran pavg AVG (-V(VDD)*I(VSUP)) FROM=1.6e-07 TO=6.4e-07
.meas tran tplh TRIG V(D1) VAL=0.6 RISE=1 TARG V(P0N_10) VAL=0.6 RISE=1
.meas tran tphl TRIG V(D1) VAL=0.6 FALL=1 TARG V(P0N_10) VAL=0.6 FALL=1
.meas tran voh MAX V(P0N_10) FROM=1.6e-07 TO=6.4e-07
.meas tran vol MIN V(P0N_10) FROM=1.6e-07 TO=6.4e-07
.end
