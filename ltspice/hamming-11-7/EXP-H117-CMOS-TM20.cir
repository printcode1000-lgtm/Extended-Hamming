* H117 encoder benchmark: CMOS
.include ../../models/65nm_bulk.pm
.include ../circuits.lib
.param VDD=1.2
.temp -20.0
VSUP VDD 0 {VDD}
VD1 D1 0 PULSE(0 1.2 2e-09 20p 20p 4e-09 8e-09)
VD2 D2 0 PULSE(0 1.2 1.6e-08 20p 20p 8e-09 1.6e-08)
VD3 D3 0 PULSE(0 1.2 1.6e-08 20p 20p 1.6e-08 3.2e-08)
VD4 D4 0 PULSE(0 1.2 1.6e-08 20p 20p 3.2e-08 6.4e-08)
VD5 D5 0 PULSE(0 1.2 1.6e-08 20p 20p 6.4e-08 1.28e-07)
VD6 D6 0 PULSE(0 1.2 1.6e-08 20p 20p 1.28e-07 2.56e-07)
VD7 D7 0 PULSE(0 1.2 1.6e-08 20p 20p 2.56e-07 5.12e-07)
XP1N1 D1 D2 P1N_1 VDD 0 XOR_CMOS
XP1N2 P1N_1 D4 P1N_2 VDD 0 XOR_CMOS
XP1N3 P1N_2 D5 P1N_3 VDD 0 XOR_CMOS
XP1N4 P1N_3 D7 P1N_4 VDD 0 XOR_CMOS
XP2N1 D1 D3 P2N_1 VDD 0 XOR_CMOS
XP2N2 P2N_1 D4 P2N_2 VDD 0 XOR_CMOS
XP2N3 P2N_2 D6 P2N_3 VDD 0 XOR_CMOS
XP2N4 P2N_3 D7 P2N_4 VDD 0 XOR_CMOS
XP4N1 D2 D3 P4N_1 VDD 0 XOR_CMOS
XP4N2 P4N_1 D4 P4N_2 VDD 0 XOR_CMOS
XP8N1 D5 D6 P8N_1 VDD 0 XOR_CMOS
XP8N2 P8N_1 D7 P8N_2 VDD 0 XOR_CMOS
CLOAD_P1 P1N_4 0 10.0f
CLOAD_P2 P2N_4 0 10.0f
CLOAD_P4 P4N_2 0 10.0f
CLOAD_P8 P8N_2 0 10.0f
.tran 20p 1.28e-07 0 20p
.meas tran pavg AVG (-V(VDD)*I(VSUP)) FROM=3.2e-08 TO=1.28e-07
.meas tran tplh TRIG V(D1) VAL=0.6 RISE=1 TARG V(P1N_4) VAL=0.6 RISE=1
.meas tran tphl TRIG V(D1) VAL=0.6 FALL=1 TARG V(P1N_4) VAL=0.6 FALL=1
.meas tran voh MAX V(P1N_4) FROM=3.2e-08 TO=1.28e-07
.meas tran vol MIN V(P1N_4) FROM=3.2e-08 TO=1.28e-07
.end
